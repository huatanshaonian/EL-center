* ac_hv_cc_DA100_DB0
VS12 S12S 0 DC 12
RLINE S12S S12 0.25
C_12 S12 0 100n
R_K S12 VK 10
C_K VK CKE 470u
RESR CKE 0 0.08
C_K2 VK 0 100n
RFILA S12 FMID 21
RFILB FMID 0 21
VHVS HVS 0 DC 250 AC 1
RHVI HVS HV 1.5
C_HV HV 0 100n
R_BL1 HV BL 470k
R_BL2 BL 0 470k
VGA GP_A0 0 DC 3.3
ROA GP_A0 GP_A 30
R_BA GP_A B_A 4.7k
R_EA B_A 0 47k
Q_A C_A B_A 0 Q2N3904
R_PA VK C_A 4.7k
R_FA C_A GF_A 220k
C_FA GF_A VK 100n
R_GA GF_A G_A 47k
CPGA G_A 0 2p
R_AA HV AN_A 100k
CPAA AN_A 0 3p
VITA HV TX_A DC 0
R_TA TX_A T_A 1m
VIKA K_A VK DC 0
XA AN_A G_A K_A T_A EM87
VGB GP_B0 0 DC 0
ROB GP_B0 GP_B 30
R_BB GP_B B_B 4.7k
R_EB B_B 0 47k
Q_B C_B B_B 0 Q2N3904
R_PB VK C_B 4.7k
R_FB C_B GF_B 220k
C_FB GF_B VK 100n
R_GB GF_B G_B 47k
CPGB G_B 0 2p
R_AB HV AN_B 100k
CPAB AN_B 0 3p
VITB HV TX_B DC 0
R_TB TX_B T_B 1m
VIKB K_B VK DC 0
XB AN_B G_B K_B T_B EM87
CCHV HV G_A 0.5p

.subckt EM87 A G K T
B1 A K I = { pwr(max(V(A,K)/85.4989909*ln(1+exp(85.4989909*(1/30.0+V(G,K)/sqrt(300.0+V(A,K)*V(A,K))))),0),1.4)/1071.77158
+ + pwr(max(V(A,K)/85.4989909*ln(1+exp(85.4989909*(1/8.0+V(G,K)/sqrt(300.0+V(A,K)*V(A,K))))),0),1.4)/329315.841 }
B2 T K I = { 1e-3*(0.807407407+0.00348148148*max(V(A,K),0)+7.40740741e-06*max(V(A,K),0)*max(V(A,K),0))*pwr(max(V(T,K),0)/250,1.5) }
VCP GX G DC 0.7
DGK GX K DGRID
CGK G K 2.5p
CGA G A 1.7p
CAK A K 3p
CTK T K 2p
.model DGRID D(IS=2.09e-10 N=3.48 RS=2k)
.ends EM87
.model Q2N3904 NPN(IS=6.734f XTI=3 EG=1.11 VAF=74.03 BF=416.4 NE=1.259 ISE=6.734f IKF=66.78m XTB=1.5 BR=.7371 NC=2 ISC=0 IKR=0 RC=1 CJC=3.638p MJC=.3085 VJC=.75 FC=.5 CJE=4.493p MJE=.2593 VJE=.75 TR=239.5n TF=301.2p ITF=.4 VTF=4 XTF=2 RB=10)
.options reltol=1e-5 vntol=1e-7 abstol=1e-12 itl4=100
.end
