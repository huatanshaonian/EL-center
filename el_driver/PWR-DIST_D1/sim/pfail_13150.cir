PWR-DIST PFAIL as drawn (RPFT 100k, Rbot 13150, RPFH 510k, RPFPU 2.2k, TL431 2.495V, inverter 2N3904)
V5 V5 0 5
V24 V24 0 PWL(0 24 20m 24 120m 18 220m 24 240m 24)
VREF REF 0 2.495
RPFT V24 SENSE 100k
RBOT SENSE 0 13150
RPFH COMP SENSE 510k
RPFPU V5 COMP 2.2k
BCTRL CTRL 0 V=V(REF)-V(SENSE)
SCOMP COMP 0 CTRL 0 SWOC
.model SWOC SW(Ron=100 Roff=1e12 Vt=0 Vh=0.0001)
RPFIB COMP INVB 68k
QPFI INV INVB 0 Q3904
RPFIP V5 INV 10k
RPFD INV DB 10k
QPFD PFEL DB 0 Q3904
RPU1 D3V3 PFEL 10k
VD3 D3V3 0 3.3
.model Q3904 NPN(IS=6.7e-15 BF=200 VAF=74 IKF=0.07 RB=10 RC=1 CJE=4.5p CJC=3.6p TF=0.3n TR=200n)
.options reltol=1e-5
.end
