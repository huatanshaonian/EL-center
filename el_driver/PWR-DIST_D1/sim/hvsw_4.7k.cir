HV switch HV-A/HV-C: P-MOS (Vth -2.5 worst case) gate 10k to source + 12V zener, 4.7k to HV_GATE_N, BSS138 + switch to GND
V12 S12 0 12
V5 S5 0 5
VEN HVEN 0 PWL(0 0 1m 0 1.001m 3.3 3m 3.3 3.001m 0 5m 0)
RSW SWN 0 0.1
RPU SWN V33 100k
V33 V33 0 3.3
MN GN HVEN SWN SWN NBSS
.model NBSS NMOS(VTO=1.3 KP=0.5)
* HV-A 12 V
RGSA GA S12 10k
DZA GA S12 DZ12
RGA GA GN 4.7k
MPA OA GA S12 S12 PNCE
RLA OA 0 30
* HV-C 5 V
RGSC GC S5 10k
DZC GC S5 DZ12
RGC GC GN 4.7k
MPC OC GC S5 S5 PNCE
RLC OC 0 50
.model DZ12 D(BV=12 IBV=1m)
.model PNCE PMOS(VTO=-2.5 KP=3)
.end
