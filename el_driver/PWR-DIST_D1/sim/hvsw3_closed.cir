HV switch fixed: one BSS138 per channel; toggle closed; HV_EN 0 -> 3.3 V (1-3 ms) -> 0
V12 S12 0 12
V5 S5 0 5
V33 V33 0 3.3
VEN HVEN 0 PWL(0 0 1m 0 1.001m 3.3 3m 3.3 3.001m 0 5m 0)
RSW SWN 0 0.1
RPU SWN V33 100k
MNA GNA HVEN SWN SWN NBSS
MNB GNB HVEN SWN SWN NBSS
MNC GNC HVEN SWN SWN NBSS
.model NBSS NMOS(VTO=1.3 KP=0.5)
RGSA GA S12 10k
DZA GA S12 DZ12
RGA GA GNA 4.7k
MPA OA GA S12 S12 PNCE
RLA OA 0 30
RGSB GB S12 10k
DZB GB S12 DZ12
RGB GB GNB 4.7k
MPB OB GB S12 S12 PNCE
RLB OB 0 40
RGSC GC S5 10k
DZC GC S5 DZ12
RGC GC GNC 1k
MPC OC GC S5 S5 PNCE
RLC OC 0 50
.model DZ12 D(BV=12 IBV=1m)
.model PNCE PMOS(VTO=-1.5 KP=3)
.end
