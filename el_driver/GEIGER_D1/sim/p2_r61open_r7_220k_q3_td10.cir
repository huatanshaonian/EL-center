pulse r61open_r7_220k q=3e-09 td=1e-05
.include E:/modeling/MIS-01/el_driver/GEIGER_D1/sim/models.lib
VHV hv 0 400
RWHV hv hvin 0.1
RWG 0 gcw 0.05
LWG gcw gc 150n
R2 hvin an 4.7Meg
CAN an gc 3p
CAK an ck 1.5p
VSHAPE shp 0 PWL(0 0 0.001 0 0.0010000375 12.1337 0.00100015 45.4068 0.0010003375 91.6426 0.0010006 140.608 0.0010009375 183.307 0.00100135 214.169 0.0010018375 231.522 0.0010024 236.688 0.0010030375 232.514 0.00100375 222.082 0.0010045375 207.958 0.0010054 191.966 0.0010063375 175.269 0.00100735 158.571 0.0010084375 142.291 0.0010096 126.694 0.0010108375 111.952 0.00101215 98.1836 0.0010135375 85.4638 0.001015 73.8358 0.0010165375 63.3132 0.00101815 53.8846 0.0010198375 45.5174 0.0010216 38.1622 0.0010234375 31.7564 0.00102535 26.2284 0.0010273375 21.5009 0.0010294 17.4938 0.0010315375 14.1271 0.00103375 11.3231 0.0010360375 9.00783 0.0010384 7.11243 0.0010408375 5.5739 0.00104335 4.33553 0.0010459375 3.3471 0.0010486 2.56471 0.0010513375 1.95052 0.00105415 1.47233 0.0010570375 1.10307 0.00106 0.820242 0.0010601 0)
BTUBE an ck I={ V(shp)*1e-6*( V(an,ck)>50 ? 1 : max(V(an,ck),0)/50 ) }
C2 ck gc 220p
R4 ck b2 22k
R7 b2 gc 220k
Q2 gmc b2 gc Q2N3904
R60 ck b5 22k
R61 b5 gc 1e12
Q5 pq b5 gc Q2N3904
R62 pq pulc 100
LWGM gmc gmw 150n
RWGM gmw gm 0.1
CWGM1 gmc 0 2.5p
CWGM2 gm 0 2.5p
LWPU pulc pulw 150n
RWPU pulw pulm 0.1
CWPU1 pulc 0 2.5p
CWPU2 pulm 0 2.5p
RWPE pulm pulse 0.2
CWPE pulse 0 30p
V33 v33 0 3.3
RPUESP v33 pulse 10k
CGPIO pulse 0 5p
R3 v5 gm 10k
CGMIN gm 0 5p
V5 v5s 0 5.0
RV5 v5s v5 0.2
C12 v5 0 47u
C13 v5 0 100n
XU4 0 gm o4 en cv4 mt mt v5 TLC555B params: VRST=1.1
C73 cv4 0 100n
R70 v5 mt 10k
C70 mt 0 100n
R75 o4 qb6 2.2k
R76 qb6 0 10k
Q6 bzn qb6 0 S8050
CLS0 v5 bzn 16n
LLSm v5 lsm1 0.99
CLSm lsm1 lsm2 1.6n
RLSm lsm2 bzn 1244
VLSm lsm2x bzn 0
R77 v5 bzn 1k
R71 bz bzp 1k
R72 bzp 0 100k
R73 bzp en 100k
C71 en 0 1u
C72 bz ac 100n
D3 0 ac D1N4148
R74 ac qb6 2.2k
V33B v33b 0 3.3
RJP v33b bz 10k
CBZ bz 0 20p
.ic v(en)=2.97 v(mt)=0 v(cv4)=3.333
.save v(ck) v(an) v(pulse) v(gm) v(o4)
.options method=gear reltol=1e-4 abstol=1e-11 vntol=1e-5 itl4=50
.end
