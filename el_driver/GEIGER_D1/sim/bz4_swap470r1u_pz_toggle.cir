bz4_swap470r1u_pz_toggle
.include E:/modeling/MIS-01/el_driver/GEIGER_D1/sim/models.lib
V5 v5s 0 5.0
RV5 v5s v5 0.2
C12 v5 0 47u
C13 v5 0 100n
XU4 0 gm o4 en cv4 mt mt v5 TLC555B params: VRST=1.1
C73 cv4 0 100n
R70 v5 mt 10k
C70 mt 0 100n
R75 o4 qb6 2.2k
R76 qb6 0 10k
Q6 bzn qb6 0 S8050
CLS0 v5 bzn 16n
LLSm v5 lsm1 0.99
CLSm lsm1 lsm2 1.6n
RLSm lsm2 lsm2x 1244
VLSm lsm2x bzn 0
R77 v5 bzn 1k
R71 bz bzp 1k
R72 bzp 0 100k
R73 bzp en 100k
C71 en 0 1u
R74 bz acx 470
C72 acx qb6 1u
D3 0 qb6 D1N4148
RACD ac 0 1G
VBZ bzd 0 PWL(0 0 0.3 0 0.3000001 3.3 0.7 3.3 0.7000001 0 2 0)
RBZ bzd bz 30
CBZ bz 0 20p
R3 v5 gm 10k
CGMIN gm 0 5p
VGMC gmctl 0 PWL(0 0 0.35 0 0.3500001 1 0.35002 1 0.3500201 0 0.5 0 0.5000001 1 0.50002 1 0.5000201 0 0.75 0 0.7500001 1 0.75002 1 0.7500201 0 0.95 0 0.9500000999999999 1 0.95002 1 0.9500200999999999 0)
SGM gm 0 gmctl 0 SWX
.save v(bz) v(bzp) v(en) v(gm) v(o4) v(qb6) v(bzn) v(ac) i(vlsm) i(vbz) i(vls2x)
.ic v(en)=0 v(mt)=0 v(cv4)=0
.options method=gear reltol=1e-4 abstol=1e-11 vntol=1e-5 itl4=50
.end
